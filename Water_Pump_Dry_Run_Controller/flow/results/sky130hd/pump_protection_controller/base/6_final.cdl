* CDL Netlist generated by OpenROAD

*.BUSDELIMITER [

.SUBCKT pump_protection_controller clk dry_run_fault fault_status
+ pump_demand pump_enable reset VDD VSS
X_43_ lockout_count\[1\] VSS VSS VDD VDD _00_ sky130_fd_sc_hd__inv_1
Xinput2 pump_demand VSS VSS VDD VDD net2 sky130_fd_sc_hd__clkdlybuf4s50_1
X_45_ lockout_count\[2\] _01_ lockout_count\[3\] VSS VSS VDD
+ VDD _14_ sky130_fd_sc_hd__nand3b_1
X_46_ net1 state\[2\] VSS VSS VDD VDD _15_ sky130_fd_sc_hd__or2b_2
X_47_ lockout_count\[2\] _03_ VSS VSS VDD VDD _16_ sky130_fd_sc_hd__nor2b_1
X_48_ state\[1\] _14_ _15_ _16_ VSS VSS VDD VDD _17_ sky130_fd_sc_hd__nand4_1
X_49_ net1 state\[2\] VSS VSS VDD VDD _18_ sky130_fd_sc_hd__nor2b_2
X_50_ _03_ state\[1\] VSS VSS VDD VDD _19_ sky130_fd_sc_hd__nor2b_1
X_51_ _18_ _19_ lockout_count\[2\] VSS VSS VDD VDD _20_ sky130_fd_sc_hd__o21ai_0
Xinput1 dry_run_fault VSS VSS VDD VDD net1 sky130_fd_sc_hd__clkdlybuf4s50_1
X_53_ _17_ _20_ net3 VSS VSS VDD VDD _07_ sky130_fd_sc_hd__a21oi_1
X_54_ _02_ _14_ _15_ state\[1\] VSS VSS VDD VDD _22_ sky130_fd_sc_hd__nand4b_1
X_55_ lockout_count\[1\] _18_ VSS VSS VDD VDD _23_ sky130_fd_sc_hd__nand2_1
X_56_ _22_ _23_ net3 VSS VSS VDD VDD _08_ sky130_fd_sc_hd__a21oi_1
X_57_ lockout_count\[0\] state\[1\] _14_ _15_ VSS VSS VDD
+ VDD _24_ sky130_fd_sc_hd__nand4b_1
X_58_ lockout_count\[0\] _18_ VSS VSS VDD VDD _25_ sky130_fd_sc_hd__nand2_1
X_59_ _24_ _25_ net3 VSS VSS VDD VDD _09_ sky130_fd_sc_hd__a21oi_1
X_60_ state\[2\] state\[0\] VSS VSS VDD VDD _26_ sky130_fd_sc_hd__nor2_1
X_61_ net3 VSS VSS VDD VDD _27_ sky130_fd_sc_hd__inv_1
X_62_ net1 net2 _26_ _27_ VSS VSS VDD VDD _04_ sky130_fd_sc_hd__o31ai_1
X_63_ net2 VSS VSS VDD VDD _28_ sky130_fd_sc_hd__inv_1
X_64_ _28_ _14_ state\[1\] VSS VSS VDD VDD _29_ sky130_fd_sc_hd__o21ai_0
X_65_ state\[1\] state\[2\] state\[0\] net1 VSS VSS VDD VDD
+ _30_ sky130_fd_sc_hd__o31ai_1
X_66_ _29_ _30_ net3 VSS VSS VDD VDD _05_ sky130_fd_sc_hd__a21oi_1
X_67_ lockout_count\[2\] _01_ lockout_count\[3\] VSS VSS VDD
+ VDD _31_ sky130_fd_sc_hd__and3b_1
X_68_ state\[1\] _31_ VSS VSS VDD VDD _32_ sky130_fd_sc_hd__nand2_1
X_69_ _26_ _32_ net1 net3 _28_ VSS VSS VDD VDD _06_ sky130_fd_sc_hd__a2111oi_0
X_70_ lockout_count\[0\] lockout_count\[1\] lockout_count\[2\]
+ VSS VSS VDD VDD _33_ sky130_fd_sc_hd__nand3_1
X_71_ lockout_count\[3\] state\[1\] _14_ _33_ VSS VSS VDD
+ VDD _34_ sky130_fd_sc_hd__nand4_1
X_72_ lockout_count\[3\] _18_ _33_ state\[1\] VSS VSS VDD
+ VDD _35_ sky130_fd_sc_hd__or4b_1
X_73_ lockout_count\[3\] _18_ VSS VSS VDD VDD _36_ sky130_fd_sc_hd__nand2_1
X_74_ _34_ _35_ _36_ net3 VSS VSS VDD VDD _10_ sky130_fd_sc_hd__a31oi_1
X_75_ _26_ _32_ net1 net3 _28_ VSS VSS VDD VDD _11_ sky130_fd_sc_hd__a2111oi_0
X_76_ state\[2\] state\[0\] state\[1\] VSS VSS VDD VDD _37_
+ sky130_fd_sc_hd__or3b_2
X_77_ state\[2\] state\[0\] net1 VSS VSS VDD VDD _38_ sky130_fd_sc_hd__o21ai_0
X_78_ state\[1\] _14_ _37_ _38_ VSS VSS VDD VDD _39_ sky130_fd_sc_hd__a22oi_1
X_79_ net1 state\[2\] state\[0\] net2 VSS VSS VDD VDD _40_
+ sky130_fd_sc_hd__nor4b_1
X_80_ state\[1\] _31_ _40_ net3 VSS VSS VDD VDD _41_ sky130_fd_sc_hd__a31oi_1
X_81_ net4 _39_ _41_ VSS VSS VDD VDD _12_ sky130_fd_sc_hd__o21a_1
X_82_ lockout_count\[0\] _00_ VSS VSS VDD VDD _01_ _02_ sky130_fd_sc_hd__ha_1
X_83_ lockout_count\[0\] lockout_count\[1\] VSS VSS VDD VDD
+ _03_ _42_ sky130_fd_sc_hd__ha_1
Xfault_status$_SDFFE_PP0P_ clknet_1_1__leaf_clk _12_ VSS VSS
+ VDD VDD net4 sky130_fd_sc_hd__dfxtp_1
Xlockout_count\[0\]$_SDFFE_PP0P_ clknet_1_0__leaf_clk _09_
+ VSS VSS VDD VDD lockout_count\[0\] sky130_fd_sc_hd__dfxtp_1
Xlockout_count\[1\]$_SDFFE_PP0P_ clknet_1_0__leaf_clk _08_
+ VSS VSS VDD VDD lockout_count\[1\] sky130_fd_sc_hd__dfxtp_1
Xlockout_count\[2\]$_SDFFE_PP0P_ clknet_1_1__leaf_clk _07_
+ VSS VSS VDD VDD lockout_count\[2\] sky130_fd_sc_hd__dfxtp_1
Xlockout_count\[3\]$_SDFFE_PP0P_ clknet_1_1__leaf_clk _10_
+ VSS VSS VDD VDD lockout_count\[3\] sky130_fd_sc_hd__dfxtp_1
Xpump_enable$_SDFF_PP0_ clknet_1_1__leaf_clk _11_ VSS VSS
+ VDD VDD net5 sky130_fd_sc_hd__dfxtp_1
Xstate\[0\]$_DFF_P_ clknet_1_1__leaf_clk _04_ VSS VSS VDD
+ VDD state\[0\] sky130_fd_sc_hd__dfxtp_1
Xstate\[1\]$_DFF_P_ clknet_1_0__leaf_clk _05_ VSS VSS VDD
+ VDD state\[1\] sky130_fd_sc_hd__dfxtp_1
Xstate\[2\]$_DFF_P_ clknet_1_0__leaf_clk _06_ VSS VSS VDD
+ VDD state\[2\] sky130_fd_sc_hd__dfxtp_1
XTAP_TAPCELL_ROW_0_0 VSS VDD sky130_fd_sc_hd__tapvpwrvgnd_1
XTAP_TAPCELL_ROW_0_1 VSS VDD sky130_fd_sc_hd__tapvpwrvgnd_1
XTAP_TAPCELL_ROW_1_2 VSS VDD sky130_fd_sc_hd__tapvpwrvgnd_1
XTAP_TAPCELL_ROW_2_3 VSS VDD sky130_fd_sc_hd__tapvpwrvgnd_1
XTAP_TAPCELL_ROW_3_4 VSS VDD sky130_fd_sc_hd__tapvpwrvgnd_1
XTAP_TAPCELL_ROW_4_5 VSS VDD sky130_fd_sc_hd__tapvpwrvgnd_1
XTAP_TAPCELL_ROW_5_6 VSS VDD sky130_fd_sc_hd__tapvpwrvgnd_1
XTAP_TAPCELL_ROW_6_7 VSS VDD sky130_fd_sc_hd__tapvpwrvgnd_1
XTAP_TAPCELL_ROW_7_8 VSS VDD sky130_fd_sc_hd__tapvpwrvgnd_1
XTAP_TAPCELL_ROW_8_9 VSS VDD sky130_fd_sc_hd__tapvpwrvgnd_1
XTAP_TAPCELL_ROW_9_10 VSS VDD sky130_fd_sc_hd__tapvpwrvgnd_1
XTAP_TAPCELL_ROW_10_11 VSS VDD sky130_fd_sc_hd__tapvpwrvgnd_1
XTAP_TAPCELL_ROW_11_12 VSS VDD sky130_fd_sc_hd__tapvpwrvgnd_1
XTAP_TAPCELL_ROW_12_13 VSS VDD sky130_fd_sc_hd__tapvpwrvgnd_1
XTAP_TAPCELL_ROW_12_14 VSS VDD sky130_fd_sc_hd__tapvpwrvgnd_1
Xinput3 reset VSS VSS VDD VDD net3 sky130_fd_sc_hd__clkdlybuf4s50_1
Xoutput4 net4 VSS VSS VDD VDD fault_status sky130_fd_sc_hd__clkdlybuf4s50_1
Xoutput5 net5 VSS VSS VDD VDD pump_enable sky130_fd_sc_hd__clkdlybuf4s50_1
Xclkbuf_0_clk clk VSS VSS VDD VDD clknet_0_clk sky130_fd_sc_hd__clkbuf_4
Xclkbuf_1_0__f_clk clknet_0_clk VSS VSS VDD VDD clknet_1_0__leaf_clk
+ sky130_fd_sc_hd__clkbuf_4
Xclkbuf_1_1__f_clk clknet_0_clk VSS VSS VDD VDD clknet_1_1__leaf_clk
+ sky130_fd_sc_hd__clkbuf_4
Xclkload0 clknet_1_0__leaf_clk VSS VSS VDD VDD _unconnected_0
+ sky130_fd_sc_hd__clkbuf_1
.ENDS pump_protection_controller
