* Extracted by KLayout on : 21/10/2026 13:06

.SUBCKT pump_protection_controller VDD VNB|VSS fault_status synth_1 synth_10
+ synth_11 synth_12 synth_13 synth_14 synth_15 synth_16 synth_17 synth_18
+ synth_19 synth_2 synth_20 synth_21 synth_22 synth_23 synth_24 synth_25
+ synth_26 synth_27 synth_28 synth_29 synth_3 synth_30 synth_31 synth_32
+ synth_33 synth_34 synth_35 synth_36 synth_37 synth_38 synth_39 synth_4
+ synth_40 synth_41 synth_42 synth_43 synth_44 synth_45 synth_46 synth_47
+ synth_48 synth_49 synth_5 synth_50 synth_51 synth_52 synth_53 synth_54
+ synth_55 synth_56 synth_57 synth_58 synth_59 synth_6 synth_60 synth_61
+ synth_7 synth_8 synth_9
X$4 VDD synth_1 VNB|VSS VDD synth_6 VNB|VSS sky130_fd_sc_hd__clkdlybuf4s50_1
X$6 VDD synth_16 synth_22 synth_2 VDD synth_32 VNB|VSS VNB|VSS
+ sky130_fd_sc_hd__o21ai_0
X$7 VDD synth_13 synth_4 synth_2 synth_14 synth_9 VNB|VSS VDD synth_10 VNB|VSS
+ sky130_fd_sc_hd__a2111oi_0
X$8 VDD synth_21 synth_16 synth_22 synth_2 VDD VNB|VSS synth_15 VNB|VSS
+ sky130_fd_sc_hd__o31ai_1
X$19 VDD synth_7 VNB|VSS VDD synth_2 VNB|VSS sky130_fd_sc_hd__clkdlybuf4s50_1
X$22 VDD synth_13 synth_4 synth_2 synth_14 synth_9 VNB|VSS VDD synth_8 VNB|VSS
+ sky130_fd_sc_hd__a2111oi_0
X$25 VDD synth_2 synth_6 synth_14 synth_3 VDD VNB|VSS synth_20 VNB|VSS
+ sky130_fd_sc_hd__o31ai_1
X$29 VDD synth_22 synth_16 synth_2 synth_6 VNB|VSS synth_23 VDD VNB|VSS
+ sky130_fd_sc_hd__nor4b_1
X$31 VDD synth_16 synth_2 VNB|VSS VDD synth_29 VNB|VSS sky130_fd_sc_hd__nor2b_2
X$33 VDD synth_2 synth_16 VNB|VSS VDD synth_36 VNB|VSS sky130_fd_sc_hd__or2b_2
X$35 VDD synth_44 synth_58 synth_59 VNB|VSS VDD VNB|VSS sky130_fd_sc_hd__nor2b_1
X$36 VNB|VSS synth_61 synth_58 synth_38 VDD synth_49 VDD VNB|VSS
+ sky130_fd_sc_hd__ha_1
X$37 VDD synth_36 synth_21 synth_24 synth_59 VDD synth_57 VNB|VSS VNB|VSS
+ sky130_fd_sc_hd__nand4_1
X$38 VDD synth_38 synth_21 synth_24 synth_36 VDD synth_47 VNB|VSS VNB|VSS
+ sky130_fd_sc_hd__nand4b_1
X$39 VDD synth_38 synth_49 synth_44 synth_51 VDD VNB|VSS VNB|VSS
+ sky130_fd_sc_hd__nand3_1
X$40 VDD synth_35 VNB|VSS synth_17 VDD VNB|VSS sky130_fd_sc_hd__clkbuf_4
X$41 VDD synth_12 VNB|VSS synth_35 VDD VNB|VSS sky130_fd_sc_hd__clkbuf_4
X$42 VDD synth_45 synth_46 synth_40 synth_4 VNB|VSS VDD synth_41 VNB|VSS
+ sky130_fd_sc_hd__a31oi_1
X$43 VDD synth_24 synth_48 synth_21 synth_51 VDD synth_40 VNB|VSS VNB|VSS
+ sky130_fd_sc_hd__nand4_1
X$44 VDD synth_38 synth_29 synth_39 VDD VNB|VSS VNB|VSS sky130_fd_sc_hd__nand2_1
X$45 VDD synth_48 synth_29 synth_45 VDD VNB|VSS VNB|VSS sky130_fd_sc_hd__nand2_1
X$46 VDD synth_49 synth_29 synth_42 VDD VNB|VSS VNB|VSS sky130_fd_sc_hd__nand2_1
X$47 VDD synth_4 synth_47 synth_39 VNB|VSS VDD synth_37 VNB|VSS
+ sky130_fd_sc_hd__a21oi_1
X$48 VDD synth_4 synth_57 synth_56 VNB|VSS VDD synth_60 VNB|VSS
+ sky130_fd_sc_hd__a21oi_1
X$49 VDD synth_4 synth_43 synth_42 VNB|VSS VDD synth_55 VNB|VSS
+ sky130_fd_sc_hd__a21oi_1
X$50 VDD synth_29 synth_50 synth_44 VDD synth_56 VNB|VSS VNB|VSS
+ sky130_fd_sc_hd__o21ai_0
X$51 VNB|VSS synth_21 synth_26 synth_28 VDD VDD VNB|VSS sky130_fd_sc_hd__dfxtp_1
X$52 VDD synth_22 synth_16 synth_21 synth_30 VNB|VSS VDD VNB|VSS
+ sky130_fd_sc_hd__or3b_2
X$53 VNB|VSS synth_48 synth_17 synth_41 VDD VDD VNB|VSS sky130_fd_sc_hd__dfxtp_1
X$54 VNB|VSS synth_38 synth_26 synth_37 VDD VDD VNB|VSS sky130_fd_sc_hd__dfxtp_1
X$55 VDD synth_26 VNB|VSS VDD VNB|VSS sky130_fd_sc_hd__clkbuf_1
X$56 VDD synth_53 synth_24 synth_36 synth_21 VDD synth_43 VNB|VSS VNB|VSS
+ sky130_fd_sc_hd__nand4b_1
X$57 VNB|VSS synth_49 synth_26 synth_55 VDD VDD VNB|VSS sky130_fd_sc_hd__dfxtp_1
X$58 VNB|VSS synth_22 synth_17 synth_20 VDD VDD VNB|VSS sky130_fd_sc_hd__dfxtp_1
X$59 VNB|VSS synth_33 synth_17 synth_31 VDD VDD VNB|VSS sky130_fd_sc_hd__dfxtp_1
X$60 VNB|VSS synth_18 synth_17 synth_10 VDD VDD VNB|VSS sky130_fd_sc_hd__dfxtp_1
X$61 VNB|VSS synth_44 synth_17 synth_60 VDD VDD VNB|VSS sky130_fd_sc_hd__dfxtp_1
X$67 VDD synth_44 synth_48 synth_52 synth_24 VNB|VSS VDD VNB|VSS
+ sky130_fd_sc_hd__nand3b_1
X$68 VDD synth_48 synth_52 synth_44 synth_25 VNB|VSS VDD VNB|VSS
+ sky130_fd_sc_hd__and3b_1
X$95 VDD synth_6 VDD VNB|VSS synth_13 VNB|VSS sky130_fd_sc_hd__inv_1
X$96 VDD synth_49 VDD VNB|VSS synth_54 VNB|VSS sky130_fd_sc_hd__inv_1
X$97 VDD synth_16 synth_22 synth_14 VNB|VSS VDD VNB|VSS sky130_fd_sc_hd__nor2_1
X$115 VDD synth_21 synth_48 synth_29 synth_51 VDD VNB|VSS synth_46 VNB|VSS
+ sky130_fd_sc_hd__or4b_1
X$121 VNB|VSS synth_16 synth_26 synth_8 VDD VDD VNB|VSS sky130_fd_sc_hd__dfxtp_1
X$122 VDD synth_13 synth_24 synth_21 VDD synth_19 VNB|VSS VNB|VSS
+ sky130_fd_sc_hd__o21ai_0
X$123 VDD synth_4 synth_19 synth_15 VNB|VSS VDD synth_28 VNB|VSS
+ sky130_fd_sc_hd__a21oi_1
X$135 VNB|VSS synth_53 synth_52 synth_38 VDD synth_54 VDD VNB|VSS
+ sky130_fd_sc_hd__ha_1
X$136 VDD synth_58 synth_21 synth_50 VNB|VSS VDD VNB|VSS
+ sky130_fd_sc_hd__nor2b_1
X$157 VDD synth_21 synth_25 synth_9 VDD VNB|VSS VNB|VSS sky130_fd_sc_hd__nand2_1
X$158 VDD synth_23 synth_25 synth_21 synth_4 VNB|VSS VDD synth_27 VNB|VSS
+ sky130_fd_sc_hd__a31oi_1
X$159 VDD synth_32 synth_30 synth_21 synth_24 VDD synth_34 VNB|VSS VNB|VSS
+ sky130_fd_sc_hd__a22oi_1
X$160 VDD synth_27 synth_34 synth_33 VDD synth_31 VNB|VSS VNB|VSS
+ sky130_fd_sc_hd__o21a_1
X$177 VDD synth_5 VNB|VSS VDD synth_4 VNB|VSS sky130_fd_sc_hd__clkdlybuf4s50_1
X$187 VDD synth_35 VNB|VSS synth_26 VDD VNB|VSS sky130_fd_sc_hd__clkbuf_4
X$244 VDD synth_18 VNB|VSS VDD synth_11 VNB|VSS sky130_fd_sc_hd__clkdlybuf4s50_1
X$245 VDD synth_33 VNB|VSS VDD fault_status VNB|VSS
+ sky130_fd_sc_hd__clkdlybuf4s50_1
X$246 VDD synth_4 VDD VNB|VSS synth_3 VNB|VSS sky130_fd_sc_hd__inv_1
.ENDS pump_protection_controller

.SUBCKT sky130_fd_sc_hd__o21a_1 VPB B1 A2 A1 VPWR X VGND VNB
M$1 VPWR synth_2 X VPB pfet_01v8_hvt L=150000U W=1000000U AS=280000000000P
+ AD=327500000000P PS=2560000U PD=1655000U
M$2 synth_2 B1 VPWR VPB pfet_01v8_hvt L=150000U W=1000000U AS=327500000000P
+ AD=195000000000P PS=1655000U PD=1390000U
M$3 synth_3 A2 synth_2 VPB pfet_01v8_hvt L=150000U W=1000000U AS=195000000000P
+ AD=152500000000P PS=1390000U PD=1305000U
M$4 VPWR A1 synth_3 VPB pfet_01v8_hvt L=150000U W=1000000U AS=152500000000P
+ AD=260000000000P PS=1305000U PD=2520000U
M$5 synth_1 B1 synth_2 VNB nfet_01v8 L=150000U W=650000U AS=169000000000P
+ AD=100750000000P PS=1820000U PD=960000U
M$6 VGND A2 synth_1 VNB nfet_01v8 L=150000U W=650000U AS=100750000000P
+ AD=87750000000P PS=960000U PD=920000U
M$7 synth_1 A1 VGND VNB nfet_01v8 L=150000U W=650000U AS=87750000000P
+ AD=169000000000P PS=920000U PD=1820000U
M$8 VGND synth_2 X VNB nfet_01v8 L=150000U W=650000U AS=169000000000P
+ AD=169000000000P PS=1820000U PD=1820000U
.ENDS sky130_fd_sc_hd__o21a_1

.SUBCKT sky130_fd_sc_hd__a22oi_1 VPB B2 B1 A1 A2 VPWR Y VGND VNB
M$1 synth_1 A1 VPWR VPB pfet_01v8_hvt L=150000U W=1000000U AS=260000000000P
+ AD=135000000000P PS=2520000U PD=1270000U
M$2 VPWR A2 synth_1 VPB pfet_01v8_hvt L=150000U W=1000000U AS=135000000000P
+ AD=300000000000P PS=1270000U PD=2600000U
M$3 synth_1 B2 Y VPB pfet_01v8_hvt L=150000U W=1000000U AS=260000000000P
+ AD=135000000000P PS=2520000U PD=1270000U
M$4 Y B1 synth_1 VPB pfet_01v8_hvt L=150000U W=1000000U AS=135000000000P
+ AD=260000000000P PS=1270000U PD=2520000U
M$5 synth_2 A1 Y VNB nfet_01v8 L=150000U W=650000U AS=169000000000P
+ AD=68250000000P PS=1820000U PD=860000U
M$6 VGND A2 synth_2 VNB nfet_01v8 L=150000U W=650000U AS=68250000000P
+ AD=234000000000P PS=860000U PD=2020000U
M$7 synth_3 B2 VGND VNB nfet_01v8 L=150000U W=650000U AS=169000000000P
+ AD=74750000000P PS=1820000U PD=880000U
M$8 Y B1 synth_3 VNB nfet_01v8 L=150000U W=650000U AS=74750000000P
+ AD=169000000000P PS=880000U PD=1820000U
.ENDS sky130_fd_sc_hd__a22oi_1

.SUBCKT sky130_fd_sc_hd__clkbuf_4 VPB A VGND X VPWR VNB
M$1 VPWR A synth_1 VPB pfet_01v8_hvt L=150000U W=1000000U AS=265000000000P
+ AD=165000000000P PS=2530000U PD=1330000U
M$2 X synth_1 VPWR VPB pfet_01v8_hvt L=150000U W=4000000U AS=585000000000P
+ AD=720000000000P PS=5170000U PD=6440000U
M$6 VGND A synth_1 VNB nfet_01v8 L=150000U W=420000U AS=111300000000P
+ AD=70350000000P PS=1370000U PD=755000U
M$7 X synth_1 VGND VNB nfet_01v8 L=150000U W=1680000U AS=246750000000P
+ AD=298200000000P PS=2855000U PD=3520000U
.ENDS sky130_fd_sc_hd__clkbuf_4

.SUBCKT sky130_fd_sc_hd__or3b_2 VPB B A C_N X VGND VPWR VNB
M$1 synth_4 A VPWR VPB pfet_01v8_hvt L=150000U W=420000U AS=148250000000P
+ AD=56700000000P PS=1340000U PD=690000U
M$2 synth_3 B synth_4 VPB pfet_01v8_hvt L=150000U W=420000U AS=56700000000P
+ AD=56700000000P PS=690000U PD=690000U
M$3 synth_2 synth_1 synth_3 VPB pfet_01v8_hvt L=150000U W=420000U
+ AS=56700000000P AD=109200000000P PS=690000U PD=1360000U
M$4 synth_1 C_N VPWR VPB pfet_01v8_hvt L=150000U W=420000U AS=145750000000P
+ AD=109200000000P PS=1335000U PD=1360000U
M$5 X synth_2 VPWR VPB pfet_01v8_hvt L=150000U W=2000000U AS=280750000000P
+ AD=283250000000P PS=2605000U PD=2610000U
M$7 VGND C_N synth_1 VNB nfet_01v8 L=150000U W=420000U AS=109200000000P
+ AD=100250000000P PS=1360000U PD=985000U
M$8 synth_2 A VGND VNB nfet_01v8 L=150000U W=420000U AS=101875000000P
+ AD=56700000000P PS=990000U PD=690000U
M$9 VGND B synth_2 VNB nfet_01v8 L=150000U W=420000U AS=56700000000P
+ AD=56700000000P PS=690000U PD=690000U
M$10 synth_2 synth_1 VGND VNB nfet_01v8 L=150000U W=420000U AS=56700000000P
+ AD=109200000000P PS=690000U PD=1360000U
M$11 X synth_2 VGND VNB nfet_01v8 L=150000U W=1300000U AS=188000000000P
+ AD=189625000000P PS=1905000U PD=1910000U
.ENDS sky130_fd_sc_hd__or3b_2

.SUBCKT sky130_fd_sc_hd__a2111oi_0 VPB D1 C1 B1 A1 A2 VGND VPWR Y VNB
M$1 synth_3 D1 Y VPB pfet_01v8_hvt L=150000U W=640000U AS=188800000000P
+ AD=67200000000P PS=1870000U PD=850000U
M$2 synth_2 C1 synth_3 VPB pfet_01v8_hvt L=150000U W=640000U AS=67200000000P
+ AD=67200000000P PS=850000U PD=850000U
M$3 synth_1 B1 synth_2 VPB pfet_01v8_hvt L=150000U W=640000U AS=67200000000P
+ AD=89600000000P PS=850000U PD=920000U
M$4 VPWR A1 synth_1 VPB pfet_01v8_hvt L=150000U W=640000U AS=89600000000P
+ AD=121600000000P PS=920000U PD=1020000U
M$5 synth_1 A2 VPWR VPB pfet_01v8_hvt L=150000U W=640000U AS=121600000000P
+ AD=195200000000P PS=1020000U PD=1890000U
M$6 Y D1 VGND VNB nfet_01v8 L=150000U W=420000U AS=126000000000P
+ AD=58800000000P PS=1440000U PD=700000U
M$7 VGND C1 Y VNB nfet_01v8 L=150000U W=420000U AS=58800000000P AD=73500000000P
+ PS=700000U PD=770000U
M$8 Y B1 VGND VNB nfet_01v8 L=150000U W=420000U AS=73500000000P AD=58800000000P
+ PS=770000U PD=700000U
M$9 synth_4 A1 Y VNB nfet_01v8 L=150000U W=420000U AS=58800000000P
+ AD=44100000000P PS=700000U PD=630000U
M$10 VGND A2 synth_4 VNB nfet_01v8 L=150000U W=420000U AS=44100000000P
+ AD=119700000000P PS=630000U PD=1410000U
.ENDS sky130_fd_sc_hd__a2111oi_0

.SUBCKT sky130_fd_sc_hd__o31ai_1 VPB A1 A2 A3 B1 VPWR VGND Y VNB
M$1 synth_3 A1 VPWR VPB pfet_01v8_hvt L=150000U W=1000000U AS=260000000000P
+ AD=135000000000P PS=2520000U PD=1270000U
M$2 synth_2 A2 synth_3 VPB pfet_01v8_hvt L=150000U W=1000000U AS=135000000000P
+ AD=135000000000P PS=1270000U PD=1270000U
M$3 Y A3 synth_2 VPB pfet_01v8_hvt L=150000U W=1000000U AS=135000000000P
+ AD=392500000000P PS=1270000U PD=1785000U
M$4 VPWR B1 Y VPB pfet_01v8_hvt L=150000U W=1000000U AS=392500000000P
+ AD=300000000000P PS=1785000U PD=2600000U
M$5 synth_1 A1 VGND VNB nfet_01v8 L=150000U W=650000U AS=169000000000P
+ AD=87750000000P PS=1820000U PD=920000U
M$6 VGND A2 synth_1 VNB nfet_01v8 L=150000U W=650000U AS=87750000000P
+ AD=87750000000P PS=920000U PD=920000U
M$7 synth_1 A3 VGND VNB nfet_01v8 L=150000U W=650000U AS=87750000000P
+ AD=198250000000P PS=920000U PD=1260000U
M$8 Y B1 synth_1 VNB nfet_01v8 L=150000U W=650000U AS=198250000000P
+ AD=221000000000P PS=1260000U PD=1980000U
.ENDS sky130_fd_sc_hd__o31ai_1

.SUBCKT sky130_fd_sc_hd__nor2_1 VPB A B Y VGND VPWR VNB
M$1 synth_1 B Y VPB pfet_01v8_hvt L=150000U W=1000000U AS=260000000000P
+ AD=105000000000P PS=2520000U PD=1210000U
M$2 VPWR A synth_1 VPB pfet_01v8_hvt L=150000U W=1000000U AS=105000000000P
+ AD=260000000000P PS=1210000U PD=2520000U
M$3 Y B VGND VNB nfet_01v8 L=150000U W=650000U AS=169000000000P AD=87750000000P
+ PS=1820000U PD=920000U
M$4 VGND A Y VNB nfet_01v8 L=150000U W=650000U AS=87750000000P AD=169000000000P
+ PS=920000U PD=1820000U
.ENDS sky130_fd_sc_hd__nor2_1

.SUBCKT sky130_fd_sc_hd__nor2b_2 VPB B_N A VGND VPWR Y VNB
M$1 VPWR B_N synth_1 VPB pfet_01v8_hvt L=150000U W=420000U AS=109200000000P
+ AD=109200000000P PS=1360000U PD=1360000U
M$2 VPWR A synth_2 VPB pfet_01v8_hvt L=150000U W=2000000U AS=415000000000P
+ AD=270000000000P PS=3830000U PD=2540000U
M$4 Y synth_1 synth_2 VPB pfet_01v8_hvt L=150000U W=2000000U AS=270000000000P
+ AD=395000000000P PS=2540000U PD=3790000U
M$6 VGND B_N synth_1 VNB nfet_01v8 L=150000U W=420000U AS=109200000000P
+ AD=109200000000P PS=1360000U PD=1360000U
M$7 Y A VGND VNB nfet_01v8 L=150000U W=1300000U AS=266500000000P
+ AD=175500000000P PS=2770000U PD=1840000U
M$9 Y synth_1 VGND VNB nfet_01v8 L=150000U W=1300000U AS=175500000000P
+ AD=256750000000P PS=1840000U PD=2740000U
.ENDS sky130_fd_sc_hd__nor2b_2

.SUBCKT sky130_fd_sc_hd__or2b_2 VPB A B_N VGND VPWR X VNB
M$1 synth_3 synth_1 synth_2 VPB pfet_01v8_hvt L=150000U W=420000U
+ AS=109200000000P AD=44100000000P PS=1360000U PD=630000U
M$2 VPWR A synth_3 VPB pfet_01v8_hvt L=150000U W=420000U AS=44100000000P
+ AD=148250000000P PS=630000U PD=1340000U
M$3 X synth_2 VPWR VPB pfet_01v8_hvt L=150000U W=2000000U AS=283250000000P
+ AD=445000000000P PS=2610000U PD=3890000U
M$5 synth_1 B_N VPWR VPB pfet_01v8_hvt L=150000U W=420000U AS=109200000000P
+ AD=109200000000P PS=1360000U PD=1360000U
M$6 VGND B_N synth_1 VNB nfet_01v8 L=150000U W=420000U AS=109200000000P
+ AD=156450000000P PS=1360000U PD=1165000U
M$7 synth_2 synth_1 VGND VNB nfet_01v8 L=150000U W=420000U AS=156450000000P
+ AD=56700000000P PS=1165000U PD=690000U
M$8 synth_2 A VGND VNB nfet_01v8 L=150000U W=420000U AS=101875000000P
+ AD=56700000000P PS=990000U PD=690000U
M$9 X synth_2 VGND VNB nfet_01v8 L=150000U W=1300000U AS=189625000000P
+ AD=289250000000P PS=1910000U PD=2840000U
.ENDS sky130_fd_sc_hd__or2b_2

.SUBCKT sky130_fd_sc_hd__ha_1 VGND SUM COUT A VPWR B VPB VNB
M$1 VPWR synth_1 SUM VPB pfet_01v8_hvt L=150000U W=1000000U AS=260000000000P
+ AD=236050000000P PS=2520000U PD=1765000U
M$2 synth_1 synth_3 VPWR VPB pfet_01v8_hvt L=150000U W=420000U AS=236050000000P
+ AD=56700000000P PS=1765000U PD=690000U
M$3 synth_5 B synth_1 VPB pfet_01v8_hvt L=150000U W=420000U AS=56700000000P
+ AD=84000000000P PS=690000U PD=820000U
M$4 VPWR A synth_5 VPB pfet_01v8_hvt L=150000U W=420000U AS=84000000000P
+ AD=149100000000P PS=820000U PD=1130000U
M$5 synth_3 B VPWR VPB pfet_01v8_hvt L=150000U W=420000U AS=149100000000P
+ AD=60900000000P PS=1130000U PD=710000U
M$6 synth_3 A VPWR VPB pfet_01v8_hvt L=150000U W=420000U AS=140750000000P
+ AD=60900000000P PS=1325000U PD=710000U
M$7 COUT synth_3 VPWR VPB pfet_01v8_hvt L=150000U W=1000000U AS=140750000000P
+ AD=260000000000P PS=1325000U PD=2520000U
M$8 synth_4 B synth_3 VNB nfet_01v8 L=150000U W=420000U AS=109200000000P
+ AD=44100000000P PS=1360000U PD=630000U
M$9 VGND A synth_4 VNB nfet_01v8 L=150000U W=420000U AS=44100000000P
+ AD=97000000000P PS=630000U PD=975000U
M$10 COUT synth_3 VGND VNB nfet_01v8 L=150000U W=650000U AS=97000000000P
+ AD=169000000000P PS=975000U PD=1820000U
M$11 synth_2 synth_3 synth_1 VNB nfet_01v8 L=150000U W=420000U AS=109200000000P
+ AD=56700000000P PS=1360000U PD=690000U
M$12 VGND B synth_2 VNB nfet_01v8 L=150000U W=420000U AS=56700000000P
+ AD=56700000000P PS=690000U PD=690000U
M$13 synth_2 A VGND VNB nfet_01v8 L=150000U W=420000U AS=56700000000P
+ AD=109200000000P PS=690000U PD=1360000U
M$14 VGND synth_1 SUM VNB nfet_01v8 L=150000U W=650000U AS=169000000000P
+ AD=169000000000P PS=1820000U PD=1820000U
.ENDS sky130_fd_sc_hd__ha_1

.SUBCKT sky130_fd_sc_hd__nor2b_1 VPB A B_N Y VGND VPWR VNB
M$1 VPWR B_N synth_1 VPB pfet_01v8_hvt L=150000U W=420000U AS=109200000000P
+ AD=157300000000P PS=1360000U PD=1390000U
M$2 synth_2 A VPWR VPB pfet_01v8_hvt L=150000U W=1000000U AS=157300000000P
+ AD=105000000000P PS=1390000U PD=1210000U
M$3 Y synth_1 synth_2 VPB pfet_01v8_hvt L=150000U W=1000000U AS=105000000000P
+ AD=260000000000P PS=1210000U PD=2520000U
M$4 VGND B_N synth_1 VNB nfet_01v8 L=150000U W=420000U AS=109200000000P
+ AD=100250000000P PS=1360000U PD=985000U
M$5 Y A VGND VNB nfet_01v8 L=150000U W=650000U AS=100250000000P AD=87750000000P
+ PS=985000U PD=920000U
M$6 VGND synth_1 Y VNB nfet_01v8 L=150000U W=650000U AS=87750000000P
+ AD=169000000000P PS=920000U PD=1820000U
.ENDS sky130_fd_sc_hd__nor2b_1

.SUBCKT sky130_fd_sc_hd__nand3b_1 VPB A_N C B Y VGND VPWR VNB
M$1 VPWR A_N synth_1 VPB pfet_01v8_hvt L=150000U W=420000U AS=109200000000P
+ AD=145750000000P PS=1360000U PD=1335000U
M$2 Y C VPWR VPB pfet_01v8_hvt L=150000U W=1000000U AS=145750000000P
+ AD=135000000000P PS=1335000U PD=1270000U
M$3 VPWR B Y VPB pfet_01v8_hvt L=150000U W=1000000U AS=135000000000P
+ AD=192500000000P PS=1270000U PD=1385000U
M$4 Y synth_1 VPWR VPB pfet_01v8_hvt L=150000U W=1000000U AS=192500000000P
+ AD=280000000000P PS=1385000U PD=2560000U
M$5 synth_1 A_N VGND VNB nfet_01v8 L=150000U W=420000U AS=100250000000P
+ AD=109200000000P PS=985000U PD=1360000U
M$6 synth_3 C VGND VNB nfet_01v8 L=150000U W=650000U AS=100250000000P
+ AD=87750000000P PS=985000U PD=920000U
M$7 synth_2 B synth_3 VNB nfet_01v8 L=150000U W=650000U AS=87750000000P
+ AD=125125000000P PS=920000U PD=1035000U
M$8 Y synth_1 synth_2 VNB nfet_01v8 L=150000U W=650000U AS=125125000000P
+ AD=182000000000P PS=1035000U PD=1860000U
.ENDS sky130_fd_sc_hd__nand3b_1

.SUBCKT sky130_fd_sc_hd__inv_1 VPB A VPWR VGND Y VNB
M$1 Y A VPWR VPB pfet_01v8_hvt L=150000U W=1000000U AS=260000000000P
+ AD=260000000000P PS=2520000U PD=2520000U
M$2 Y A VGND VNB nfet_01v8 L=150000U W=650000U AS=169000000000P
+ AD=169000000000P PS=1820000U PD=1820000U
.ENDS sky130_fd_sc_hd__inv_1

.SUBCKT sky130_fd_sc_hd__clkdlybuf4s50_1 VPB A VGND VPWR X VNB
M$1 synth_3 synth_2 VPWR VPB pfet_01v8_hvt L=500000U W=820000U AS=155750000000P
+ AD=217300000000P PS=1325000U PD=2170000U
M$2 X synth_3 VPWR VPB pfet_01v8_hvt L=150000U W=1000000U AS=155750000000P
+ AD=355000000000P PS=1325000U PD=2710000U
M$3 VPWR A synth_1 VPB pfet_01v8_hvt L=150000U W=1000000U AS=270000000000P
+ AD=170100000000P PS=2540000U PD=1360000U
M$4 synth_2 synth_1 VPWR VPB pfet_01v8_hvt L=500000U W=820000U AS=170100000000P
+ AD=217300000000P PS=1360000U PD=2170000U
M$5 X synth_3 VGND VNB nfet_01v8 L=150000U W=420000U AS=97000000000P
+ AD=149100000000P PS=975000U PD=1550000U
M$6 VGND synth_2 synth_3 VNB nfet_01v8 L=500000U W=650000U AS=172250000000P
+ AD=97000000000P PS=1830000U PD=975000U
M$7 VGND A synth_1 VNB nfet_01v8 L=150000U W=420000U AS=113400000000P
+ AD=104350000000P PS=1380000U PD=1010000U
M$8 synth_2 synth_1 VGND VNB nfet_01v8 L=500000U W=650000U AS=104350000000P
+ AD=169000000000P PS=1010000U PD=1820000U
.ENDS sky130_fd_sc_hd__clkdlybuf4s50_1

.SUBCKT sky130_fd_sc_hd__dfxtp_1 VGND Q CLK D VPWR VPB VNB
M$1 synth_3 D VPWR VPB pfet_01v8_hvt L=150000U W=420000U AS=109200000000P
+ AD=57750000000P PS=1360000U PD=695000U
M$2 synth_4 synth_2 synth_3 VPB pfet_01v8_hvt L=150000U W=420000U
+ AS=57750000000P AD=68250000000P PS=695000U PD=745000U
M$3 synth_10 synth_1 synth_4 VPB pfet_01v8_hvt L=150000U W=420000U
+ AS=68250000000P AD=76650000000P PS=745000U PD=785000U
M$4 synth_10 synth_5 VPWR VPB pfet_01v8_hvt L=150000U W=420000U
+ AS=178875000000P AD=76650000000P PS=1260000U PD=785000U
M$5 synth_5 synth_4 VPWR VPB pfet_01v8_hvt L=150000U W=750000U AS=178875000000P
+ AD=109500000000P PS=1260000U PD=1075000U
M$6 synth_6 synth_1 synth_5 VPB pfet_01v8_hvt L=150000U W=420000U
+ AS=109500000000P AD=56700000000P PS=1075000U PD=690000U
M$7 synth_11 synth_2 synth_6 VPB pfet_01v8_hvt L=150000U W=420000U
+ AS=56700000000P AD=88200000000P PS=690000U PD=840000U
M$8 VPWR synth_7 synth_11 VPB pfet_01v8_hvt L=150000U W=420000U AS=88200000000P
+ AD=111300000000P PS=840000U PD=1370000U
M$9 VPWR CLK synth_1 VPB pfet_01v8_hvt L=150000U W=640000U AS=166400000000P
+ AD=86400000000P PS=1800000U PD=910000U
M$10 synth_2 synth_1 VPWR VPB pfet_01v8_hvt L=150000U W=640000U AS=86400000000P
+ AD=166400000000P PS=910000U PD=1800000U
M$11 VPWR synth_6 synth_7 VPB pfet_01v8_hvt L=150000U W=1000000U
+ AS=270000000000P AD=135000000000P PS=2540000U PD=1270000U
M$12 Q synth_7 VPWR VPB pfet_01v8_hvt L=150000U W=1000000U AS=135000000000P
+ AD=260000000000P PS=1270000U PD=2520000U
M$13 VGND synth_6 synth_7 VNB nfet_01v8 L=150000U W=650000U AS=169000000000P
+ AD=87750000000P PS=1820000U PD=920000U
M$14 Q synth_7 VGND VNB nfet_01v8 L=150000U W=650000U AS=87750000000P
+ AD=169000000000P PS=920000U PD=1820000U
M$15 VGND CLK synth_1 VNB nfet_01v8 L=150000U W=420000U AS=109200000000P
+ AD=56700000000P PS=1360000U PD=690000U
M$16 synth_2 synth_1 VGND VNB nfet_01v8 L=150000U W=420000U AS=56700000000P
+ AD=109200000000P PS=690000U PD=1360000U
M$17 synth_4 synth_1 synth_3 VNB nfet_01v8 L=150000U W=360000U AS=81300000000P
+ AD=62100000000P PS=830000U PD=705000U
M$18 synth_9 synth_2 synth_4 VNB nfet_01v8 L=150000U W=360000U AS=62100000000P
+ AD=69600000000P PS=705000U PD=765000U
M$19 synth_6 synth_2 synth_5 VNB nfet_01v8 L=150000U W=360000U AS=98900000000P
+ AD=68400000000P PS=995000U PD=740000U
M$20 synth_8 synth_1 synth_6 VNB nfet_01v8 L=150000U W=360000U AS=68400000000P
+ AD=66000000000P PS=740000U PD=745000U
M$21 synth_3 D VGND VNB nfet_01v8 L=150000U W=420000U AS=109200000000P
+ AD=81300000000P PS=1360000U PD=830000U
M$22 VGND synth_5 synth_9 VNB nfet_01v8 L=150000U W=420000U AS=69600000000P
+ AD=120950000000P PS=765000U PD=1085000U
M$23 VGND synth_7 synth_8 VNB nfet_01v8 L=150000U W=420000U AS=66000000000P
+ AD=109200000000P PS=745000U PD=1360000U
M$24 synth_5 synth_4 VGND VNB nfet_01v8 L=150000U W=640000U AS=120950000000P
+ AD=98900000000P PS=1085000U PD=995000U
.ENDS sky130_fd_sc_hd__dfxtp_1

.SUBCKT sky130_fd_sc_hd__clkbuf_1 VPB A VGND VPWR VNB
M$1 VPWR synth_1 X VPB pfet_01v8_hvt L=150000U W=790000U AS=205400000000P
+ AD=114550000000P PS=2100000U PD=1080000U
M$2 synth_1 A VPWR VPB pfet_01v8_hvt L=150000U W=790000U AS=114550000000P
+ AD=205400000000P PS=1080000U PD=2100000U
M$3 VGND synth_1 X VNB nfet_01v8 L=150000U W=520000U AS=135200000000P
+ AD=75400000000P PS=1560000U PD=810000U
M$4 synth_1 A VGND VNB nfet_01v8 L=150000U W=520000U AS=75400000000P
+ AD=135200000000P PS=810000U PD=1560000U
.ENDS sky130_fd_sc_hd__clkbuf_1

.SUBCKT sky130_fd_sc_hd__nor4b_1 VPB C B A D_N VGND Y VPWR VNB
M$1 synth_1 D_N VPWR VPB pfet_01v8_hvt L=150000U W=420000U AS=145750000000P
+ AD=109200000000P PS=1335000U PD=1360000U
M$2 synth_4 synth_1 Y VPB pfet_01v8_hvt L=150000U W=1000000U AS=520000000000P
+ AD=135000000000P PS=3040000U PD=1270000U
M$3 synth_3 C synth_4 VPB pfet_01v8_hvt L=150000U W=1000000U AS=135000000000P
+ AD=165000000000P PS=1270000U PD=1330000U
M$4 synth_2 B synth_3 VPB pfet_01v8_hvt L=150000U W=1000000U AS=165000000000P
+ AD=135000000000P PS=1330000U PD=1270000U
M$5 VPWR A synth_2 VPB pfet_01v8_hvt L=150000U W=1000000U AS=135000000000P
+ AD=145750000000P PS=1270000U PD=1335000U
M$6 Y synth_1 VGND VNB nfet_01v8 L=150000U W=650000U AS=182000000000P
+ AD=87750000000P PS=1860000U PD=920000U
M$7 VGND C Y VNB nfet_01v8 L=150000U W=650000U AS=87750000000P AD=107250000000P
+ PS=920000U PD=980000U
M$8 Y B VGND VNB nfet_01v8 L=150000U W=650000U AS=107250000000P AD=87750000000P
+ PS=980000U PD=920000U
M$9 VGND A Y VNB nfet_01v8 L=150000U W=650000U AS=87750000000P AD=100250000000P
+ PS=920000U PD=985000U
M$10 synth_1 D_N VGND VNB nfet_01v8 L=150000U W=420000U AS=100250000000P
+ AD=109200000000P PS=985000U PD=1360000U
.ENDS sky130_fd_sc_hd__nor4b_1

.SUBCKT sky130_fd_sc_hd__a31oi_1 VPB A3 A2 A1 B1 VGND VPWR Y VNB
M$1 synth_1 A3 VPWR VPB pfet_01v8_hvt L=150000U W=1000000U AS=260000000000P
+ AD=135000000000P PS=2520000U PD=1270000U
M$2 VPWR A2 synth_1 VPB pfet_01v8_hvt L=150000U W=1000000U AS=135000000000P
+ AD=152500000000P PS=1270000U PD=1305000U
M$3 synth_1 A1 VPWR VPB pfet_01v8_hvt L=150000U W=1000000U AS=152500000000P
+ AD=162500000000P PS=1305000U PD=1325000U
M$4 Y B1 synth_1 VPB pfet_01v8_hvt L=150000U W=1000000U AS=162500000000P
+ AD=270000000000P PS=1325000U PD=2540000U
M$5 synth_3 A3 VGND VNB nfet_01v8 L=150000U W=650000U AS=169000000000P
+ AD=68250000000P PS=1820000U PD=860000U
M$6 synth_2 A2 synth_3 VNB nfet_01v8 L=150000U W=650000U AS=68250000000P
+ AD=118625000000P PS=860000U PD=1015000U
M$7 Y A1 synth_2 VNB nfet_01v8 L=150000U W=650000U AS=118625000000P
+ AD=105625000000P PS=1015000U PD=975000U
M$8 VGND B1 Y VNB nfet_01v8 L=150000U W=650000U AS=105625000000P
+ AD=175500000000P PS=975000U PD=1840000U
.ENDS sky130_fd_sc_hd__a31oi_1

.SUBCKT sky130_fd_sc_hd__or4b_1 VPB D_N A B C VPWR VGND X VNB
M$1 synth_3 synth_1 synth_2 VPB pfet_01v8_hvt L=150000U W=420000U
+ AS=109200000000P AD=68250000000P PS=1360000U PD=745000U
M$2 synth_5 C synth_3 VPB pfet_01v8_hvt L=150000U W=420000U AS=68250000000P
+ AD=45150000000P PS=745000U PD=635000U
M$3 synth_4 B synth_5 VPB pfet_01v8_hvt L=150000U W=420000U AS=45150000000P
+ AD=64050000000P PS=635000U PD=725000U
M$4 VPWR A synth_4 VPB pfet_01v8_hvt L=150000U W=420000U AS=64050000000P
+ AD=148250000000P PS=725000U PD=1340000U
M$5 X synth_2 VPWR VPB pfet_01v8_hvt L=150000U W=1000000U AS=148250000000P
+ AD=275000000000P PS=1340000U PD=2550000U
M$6 synth_1 D_N VPWR VPB pfet_01v8_hvt L=150000U W=420000U AS=109200000000P
+ AD=109200000000P PS=1360000U PD=1360000U
M$7 synth_2 synth_1 VGND VNB nfet_01v8 L=150000U W=420000U AS=109200000000P
+ AD=64050000000P PS=1360000U PD=725000U
M$8 VGND C synth_2 VNB nfet_01v8 L=150000U W=420000U AS=64050000000P
+ AD=56700000000P PS=725000U PD=690000U
M$9 synth_2 B VGND VNB nfet_01v8 L=150000U W=420000U AS=56700000000P
+ AD=56700000000P PS=690000U PD=690000U
M$10 synth_2 A VGND VNB nfet_01v8 L=150000U W=420000U AS=101875000000P
+ AD=56700000000P PS=990000U PD=690000U
M$11 X synth_2 VGND VNB nfet_01v8 L=150000U W=650000U AS=101875000000P
+ AD=178750000000P PS=990000U PD=1850000U
M$12 synth_1 D_N VGND VNB nfet_01v8 L=150000U W=420000U AS=109200000000P
+ AD=109200000000P PS=1360000U PD=1360000U
.ENDS sky130_fd_sc_hd__or4b_1

.SUBCKT sky130_fd_sc_hd__nand3_1 VPB A B C Y VPWR VGND VNB
M$1 Y C VPWR VPB pfet_01v8_hvt L=150000U W=1000000U AS=260000000000P
+ AD=135000000000P PS=2520000U PD=1270000U
M$2 VPWR B Y VPB pfet_01v8_hvt L=150000U W=1000000U AS=135000000000P
+ AD=165000000000P PS=1270000U PD=1330000U
M$3 Y A VPWR VPB pfet_01v8_hvt L=150000U W=1000000U AS=165000000000P
+ AD=260000000000P PS=1330000U PD=2520000U
M$4 synth_2 C VGND VNB nfet_01v8 L=150000U W=650000U AS=169000000000P
+ AD=87750000000P PS=1820000U PD=920000U
M$5 synth_1 B synth_2 VNB nfet_01v8 L=150000U W=650000U AS=87750000000P
+ AD=107250000000P PS=920000U PD=980000U
M$6 Y A synth_1 VNB nfet_01v8 L=150000U W=650000U AS=107250000000P
+ AD=169000000000P PS=980000U PD=1820000U
.ENDS sky130_fd_sc_hd__nand3_1

.SUBCKT sky130_fd_sc_hd__and3b_1 VPB C B A_N X VGND VPWR VNB
M$1 VPWR C synth_2 VPB pfet_01v8_hvt L=150000U W=420000U AS=74375000000P
+ AD=142225000000P PS=815000U PD=1335000U
M$2 VPWR synth_1 synth_2 VPB pfet_01v8_hvt L=150000U W=420000U AS=108500000000P
+ AD=56700000000P PS=1360000U PD=690000U
M$3 VPWR B synth_2 VPB pfet_01v8_hvt L=150000U W=420000U AS=74375000000P
+ AD=56700000000P PS=815000U PD=690000U
M$4 X synth_2 VPWR VPB pfet_01v8_hvt L=150000U W=1000000U AS=142225000000P
+ AD=260000000000P PS=1335000U PD=2520000U
M$5 synth_1 A_N VPWR VPB pfet_01v8_hvt L=150000U W=420000U AS=109200000000P
+ AD=108700000000P PS=1360000U PD=1360000U
M$6 synth_4 synth_1 synth_2 VNB nfet_01v8 L=150000U W=420000U AS=107825000000P
+ AD=44100000000P PS=1360000U PD=630000U
M$7 synth_3 B synth_4 VNB nfet_01v8 L=150000U W=420000U AS=44100000000P
+ AD=53550000000P PS=630000U PD=675000U
M$8 synth_3 C VGND VNB nfet_01v8 L=150000U W=420000U AS=122275000000P
+ AD=53550000000P PS=1080000U PD=675000U
M$9 X synth_2 VGND VNB nfet_01v8 L=150000U W=650000U AS=122275000000P
+ AD=169000000000P PS=1080000U PD=1820000U
M$10 synth_1 A_N VGND VNB nfet_01v8 L=150000U W=420000U AS=109200000000P
+ AD=107850000000P PS=1360000U PD=1360000U
.ENDS sky130_fd_sc_hd__and3b_1

.SUBCKT sky130_fd_sc_hd__nand2_1 VPB A B Y VPWR VGND VNB
M$1 Y B VPWR VPB pfet_01v8_hvt L=150000U W=1000000U AS=260000000000P
+ AD=135000000000P PS=2520000U PD=1270000U
M$2 VPWR A Y VPB pfet_01v8_hvt L=150000U W=1000000U AS=135000000000P
+ AD=260000000000P PS=1270000U PD=2520000U
M$3 synth_1 B VGND VNB nfet_01v8 L=150000U W=650000U AS=169000000000P
+ AD=87750000000P PS=1820000U PD=920000U
M$4 Y A synth_1 VNB nfet_01v8 L=150000U W=650000U AS=87750000000P
+ AD=169000000000P PS=920000U PD=1820000U
.ENDS sky130_fd_sc_hd__nand2_1

.SUBCKT sky130_fd_sc_hd__nand4b_1 VPB A_N B C D VPWR Y VGND VNB
M$1 VPWR A_N synth_1 VPB pfet_01v8_hvt L=150000U W=420000U AS=109200000000P
+ AD=145750000000P PS=1360000U PD=1335000U
M$2 Y D VPWR VPB pfet_01v8_hvt L=150000U W=1000000U AS=145750000000P
+ AD=135000000000P PS=1335000U PD=1270000U
M$3 VPWR C Y VPB pfet_01v8_hvt L=150000U W=1000000U AS=135000000000P
+ AD=192500000000P PS=1270000U PD=1385000U
M$4 Y B VPWR VPB pfet_01v8_hvt L=150000U W=1000000U AS=192500000000P
+ AD=195000000000P PS=1385000U PD=1390000U
M$5 VPWR synth_1 Y VPB pfet_01v8_hvt L=150000U W=1000000U AS=195000000000P
+ AD=280000000000P PS=1390000U PD=2560000U
M$6 synth_1 A_N VGND VNB nfet_01v8 L=150000U W=420000U AS=118125000000P
+ AD=111300000000P PS=1040000U PD=1370000U
M$7 synth_2 D VGND VNB nfet_01v8 L=150000U W=650000U AS=118125000000P
+ AD=87750000000P PS=1040000U PD=920000U
M$8 synth_4 C synth_2 VNB nfet_01v8 L=150000U W=650000U AS=87750000000P
+ AD=125125000000P PS=920000U PD=1035000U
M$9 synth_3 B synth_4 VNB nfet_01v8 L=150000U W=650000U AS=125125000000P
+ AD=126750000000P PS=1035000U PD=1040000U
M$10 Y synth_1 synth_3 VNB nfet_01v8 L=150000U W=650000U AS=126750000000P
+ AD=227500000000P PS=1040000U PD=2000000U
.ENDS sky130_fd_sc_hd__nand4b_1

.SUBCKT sky130_fd_sc_hd__a21oi_1 VPB B1 A1 A2 VGND VPWR Y VNB
M$1 synth_1 B1 Y VPB pfet_01v8_hvt L=150000U W=1000000U AS=265000000000P
+ AD=140000000000P PS=2530000U PD=1280000U
M$2 VPWR A1 synth_1 VPB pfet_01v8_hvt L=150000U W=1000000U AS=140000000000P
+ AD=147500000000P PS=1280000U PD=1295000U
M$3 synth_1 A2 VPWR VPB pfet_01v8_hvt L=150000U W=1000000U AS=147500000000P
+ AD=265000000000P PS=1295000U PD=2530000U
M$4 Y B1 VGND VNB nfet_01v8 L=150000U W=650000U AS=172250000000P
+ AD=91000000000P PS=1830000U PD=930000U
M$5 synth_2 A1 Y VNB nfet_01v8 L=150000U W=650000U AS=91000000000P
+ AD=95875000000P PS=930000U PD=945000U
M$6 VGND A2 synth_2 VNB nfet_01v8 L=150000U W=650000U AS=95875000000P
+ AD=172250000000P PS=945000U PD=1830000U
.ENDS sky130_fd_sc_hd__a21oi_1

.SUBCKT sky130_fd_sc_hd__o21ai_0 VPB A1 A2 B1 VPWR Y VGND VNB
M$1 synth_2 A1 VPWR VPB pfet_01v8_hvt L=150000U W=640000U AS=169600000000P
+ AD=76800000000P PS=1810000U PD=880000U
M$2 Y A2 synth_2 VPB pfet_01v8_hvt L=150000U W=640000U AS=76800000000P
+ AD=89600000000P PS=880000U PD=920000U
M$3 VPWR B1 Y VPB pfet_01v8_hvt L=150000U W=640000U AS=89600000000P
+ AD=182400000000P PS=920000U PD=1850000U
M$4 VGND A1 synth_1 VNB nfet_01v8 L=150000U W=420000U AS=111300000000P
+ AD=58800000000P PS=1370000U PD=700000U
M$5 synth_1 A2 VGND VNB nfet_01v8 L=150000U W=420000U AS=58800000000P
+ AD=58800000000P PS=700000U PD=700000U
M$6 Y B1 synth_1 VNB nfet_01v8 L=150000U W=420000U AS=58800000000P
+ AD=111300000000P PS=700000U PD=1370000U
.ENDS sky130_fd_sc_hd__o21ai_0

.SUBCKT sky130_fd_sc_hd__nand4_1 VPB C A B D VPWR Y VGND VNB
M$1 Y D VPWR VPB pfet_01v8_hvt L=150000U W=1000000U AS=260000000000P
+ AD=135000000000P PS=2520000U PD=1270000U
M$2 VPWR C Y VPB pfet_01v8_hvt L=150000U W=1000000U AS=135000000000P
+ AD=135000000000P PS=1270000U PD=1270000U
M$3 Y B VPWR VPB pfet_01v8_hvt L=150000U W=1000000U AS=135000000000P
+ AD=165000000000P PS=1270000U PD=1330000U
M$4 VPWR A Y VPB pfet_01v8_hvt L=150000U W=1000000U AS=165000000000P
+ AD=300000000000P PS=1330000U PD=2600000U
M$5 synth_3 D VGND VNB nfet_01v8 L=150000U W=650000U AS=169000000000P
+ AD=87750000000P PS=1820000U PD=920000U
M$6 synth_2 C synth_3 VNB nfet_01v8 L=150000U W=650000U AS=87750000000P
+ AD=87750000000P PS=920000U PD=920000U
M$7 synth_1 B synth_2 VNB nfet_01v8 L=150000U W=650000U AS=87750000000P
+ AD=107250000000P PS=920000U PD=980000U
M$8 Y A synth_1 VNB nfet_01v8 L=150000U W=650000U AS=107250000000P
+ AD=195000000000P PS=980000U PD=1900000U
.ENDS sky130_fd_sc_hd__nand4_1
